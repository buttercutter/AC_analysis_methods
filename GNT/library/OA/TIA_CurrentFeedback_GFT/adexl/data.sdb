ADE simulation setup
Run mode: Single Run, Sweeps and Corners
Tests:
  basic: Test1/CurrentFeedbackAmp1/schematic, simulator spectre
    Outputs: nil
Global variables:
  Rf = 10k
  ri = 50
  Z = 1M
  ZBW = 100M
