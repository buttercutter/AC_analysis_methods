** adapted to spectre syntax from http://ekv.epfl.ch/page-92010-en.html **

*** SPICE Models
*** Models created by Daniel Foty.
*** (c) 2001, Gilgamesh Associates and EPFL - All rights reserved.
*** These models are provided without warranty or support.
*** These models represent a completely fictitious 0.15um process, and do
*** NOT correspond to any real silicon process. They are provided expressly for
*** use in the examples provided in this text, and should not be used for any
*** real silicon product design.
*** NMOS EKV MOSFET Model ***************************************************
*** Level=44 in WinSPICE and ELDO, Level=55 in ADM/HSPICE, Level=5 in PSPICE,
*** Level=EKV in Spectre
*** Lmin=0.15u Wmin=1.05u (If Scale=0.15u then Lmin=1 and Wmin=7)
*---------------
model NMOS015 ekv
*** sETUP pARAMETERS
*+ update=2.6
*** pROCESS rELATED mODEL pARAMETERS
+ cox=9.083e-3 xj=0.15e-6
*** iNTRINSIC mODEL pARAMETERS
+ vto=0.4 gamma=0.71 phi=0.97 kp=453e-6
+ e0=88.0e6 ucrit=4.0e6
+ dl=-0.05e-6 dw=-0.02e-6
+ lambda = 0.30 leta=0.28 weta=0
+ q0=280e-6 lk=0.5e-6
*** sUBSTRATE cURRENT pARAMETERS
+ ibn=1.0 iba=200e6 ibb=350e6
*** iNTRINSIC mODEL tEMPERATURE pARAMETERS
+ tnom=27.0 tcv=1.5e-3 bex=-1.5 ucex=1.7 ibbt=0
*** 1/F nOISE mODEL pARAMETERS
+ kf=1e-27 af=1
*** sERIES rESISTANCE AND aREA cALCULATION pARAMETERS
+ hdif=0.24E-6 acm=3 rsh=5.0 rs=1250.526
+ rd=1250.526 ldif=0.07E-6
*** jUNCTION cURRENT pARAMETERS
+ js=1.0e-6 jsw=5.0e-11 xti=0 n=1.5
*** jUNCTION cAPACITANCES pARAMETERS
+ cj=1.0e-3 cjsw=2.0e-10 cjgate=5.0e-10
+ mj=0.5 mjsw=0.3 pb=0.9 pbsw=0.9 fc=0.5
*** gATE oVERLAP cAPACITANCES
+ cgso=3.0e-10 cgdo=3.0e-10 cgbo=3.0e-11

model NMOS015noCOX ekv
*** sETUP pARAMETERS
*+ update=2.6
*** pROCESS rELATED mODEL pARAMETERS
+ cox=0 xj=0.15e-6
*** iNTRINSIC mODEL pARAMETERS
+ vto=0.4 gamma=0.71 phi=0.97 kp=453e-6
+ e0=88.0e6 ucrit=4.0e6
+ dl=-0.05e-6 dw=-0.02e-6
+ lambda = 0.30 leta=0.28 weta=0
+ q0=280e-6 lk=0.5e-6
*** sUBSTRATE cURRENT pARAMETERS
+ ibn=1.0 iba=200e6 ibb=350e6
*** iNTRINSIC mODEL tEMPERATURE pARAMETERS
+ tnom=27.0 tcv=1.5e-3 bex=-1.5 ucex=1.7 ibbt=0
*** 1/F nOISE mODEL pARAMETERS
+ kf=1e-27 af=1
*** sERIES rESISTANCE AND aREA cALCULATION pARAMETERS
+ hdif=0.24E-6 acm=3 rsh=5.0 rs=1250.526
+ rd=1250.526 ldif=0.07E-6
*** jUNCTION cURRENT pARAMETERS
+ js=1.0e-6 jsw=5.0e-11 xti=0 n=1.5
*** jUNCTION cAPACITANCES pARAMETERS
+ cj=1.0e-3 cjsw=2.0e-10 cjgate=5.0e-10
+ mj=0.5 mjsw=0.3 pb=0.9 pbsw=0.9 fc=0.5
*** gATE oVERLAP cAPACITANCES
+ cgso=3.0e-10 cgdo=3.0e-10 cgbo=3.0e-11

*** PMOS EKV MOSFET Model ***************************************************
*** Level=44 in WinSPICE and ELDO, Level=55 in ADM/HSPICE, Level=5 in PSPICE,
*** Level=EKV in Spectre
*** Lmin=0.15u Wmin=1.05u (If Scale=0.15u then Lmin=1 and Wmin=7)
*---------------
*.MODEL pmos pmos
*+ LEVEL = 44
**** Setup Parameters
*+ UPDATE = 2.6
**** Process Related Model Parameters
*+ COX=9.083E-3 XJ=0.15E-6
**** Intrinsic Model Parameters
*+ VTO=-0.4 GAMMA=0.69 PHI=0.87 KP=92.15E-6
*+ E0=51.0E6 UCRIT=18.0E6
*+ DL=-0.05E-6 DW=-0.03E-6
*+ LAMBDA=1.1 LETA=0.45 WETA=0
*+ Q0=200E-6 LK=0.6E-6
**** Substrate Current Parameters
*+ IBN=1.0 IBA=0.0 IBB=300E6
**** Intrinsic Model Temperature Parameters
*+ TNOM=25.0 TCV=-1.4E-3 BEX=-1.4 UCEX=2.0 IBBT=0.0
**** 1/f Noise Model Parameters
*+ KF=1.0E-28 AF=1
**** Series Resistance and Area Calculation Parameters
*+ HDIF=0.24E-6 ACM=3 RSH=5.0 RS=3145.263
*+ RD=3145.263 LDIF=0.07e-6
**** Junction Current Parameters
*+ JS=1.0E-7 JSW=5.0E-12 XTI=0 N=1.8
**** Junction Capacitances Parameters
*+ CJ=1.3E-3 CJSW=2.5E-10 CJGATE=5.5E-10
*+ MJ=0.5 MJSW=0.35 PB=0.9 PBSW=0.9 FC=0.5
**** Gate Overlap Capacitances
*+ CGSO=3.2E-10 CGDO=3.2E-10 CGBO=3.0E-11
